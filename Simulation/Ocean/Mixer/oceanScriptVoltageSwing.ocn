simulator( 'spectre )
design(	 "/ssd_4TB/divake/AICircuit/Shared/Netlists/Mixer/netlist")
resultsDir( "/ssd_4TB/divake/AICircuit/Shared/Results/Mixer" )
modelFile(
    '("/ssd_4TB/divake/AICircuit/Shared/Model/45n270AModels.sp" "")
)
analysis('tran ?stop "20n"  ?triseTemp "1.0"  )
analysis('dc ?saveOppoint t  )
desVar(	  "Itail" 2m	)
desVar(	  "C" 1p	)
desVar(	  "flo" 5.5G	)
desVar(	  "frf" 5.6G	)
desVar(	  "pacmag" 1	)
desVar(	  "plo" 10	)
desVar(	  "prf" -40	)
desVar(	  "R" 350	)
desVar(	  "WLO" 10u	)
desVar(	  "WRF" 20u	)
envOption(
	'analysisOrder  list("dc" "tran")
)
saveOption( 'pwr "all" )
saveOption( 'save "all" )
temp( 27 )
run()
selectResult( 'dcOp )
selectResult( 'tran )
IFVoltageSwing = (peakToPeak(v("/IF_out" ?result "tran")) / 2)

filePtr = outfile("./results.txt" "w")
ocnPrint( ?output filePtr "Simulated performance ..." )
ocnPrint( ?output filePtr ?numberNotation 'scientific ?numSpaces 1 "IFVoltageSwing:" IFVoltageSwing)
close(filePtr)
